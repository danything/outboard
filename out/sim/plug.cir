* plug.cir - scene 1: hot plug. SWN off, S ramps 0 -> VIN in TR (starts at t = 1 ms)
.param VIN=4.6
.param TR=10u
.param R14=100k
.param R15=150k
.param C20=1u
.param C32=33n
.param CL=100u
.param RL=1e9
.param VTO=-0.9
.param CS=44u
VS   s 0 PWL(0 0 1m 0 {1m+TR} {VIN})
CS   s 0 {CS}
VCTL ctl 0 0
.include hs_switch.cir
.tran 20u 700m 0 200u
.end
