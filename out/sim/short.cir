* short.cir - scene 4: OUT shorted to GND through 0.1 Ohm at t = 1 ms (from on steady state),
* F1 stays 0.2 Ohm (no trip), SWN opens at t = 51 ms
.param VBST=12.36
.param RSRC=1
.param R14=100k
.param R15=150k
.param C20=1u
.param C32=33n
.param CL=100u
.param RL=24
.param VTO=-0.9
.param CS=44u
VB   src 0 {VBST}
RSRC src s {RSRC}
CS   s 0 {CS}
VCTL ctl 0 PWL(0 1 51m 1 51.001m 0)
VSH  shc 0 PWL(0 0 1m 0 1.001m 1)
S2   out 0 shc 0 sw_short
.model sw_short sw (vt=0.5 vh=0 ron=0.1 roff=1e12)
.include hs_switch.cir
.tran 10u 1200m 0 100u
.end
