* hs_switch.cir - common part of the 12V high-side soft-start switch (included by plug/on/off/short.cir)
* Nodes: s = boost output / Q1 source, g = gate, d = Q1 drain, out = card side after F1, ctl = SWN control (1 = on)
* Params expected from the scene deck: R14 R15 C20 C32 CL RL VTO

* --- Q1 AO3401A, coarse model -------------------------------------------------
* LEVEL=1 PMOS. KP and the series resistance are fitted to the datasheet typ values
*   Rds(on) 47 mOhm @ Vgs=-4.5V, 60 mOhm @ Vgs=-2.5V  (with VTO=-0.9: 1/(KP*(|Vgs|-0.9)) + 36 mOhm)
*   gfs = sqrt(2*KP*Id) = 14.6 S @ 4 A (datasheet 17 S typ)
* Capacitances are fixed external parts (datasheet @ Vds=-15V: Ciss 645p, Coss 80p, Crss 55p).
.model pm_ao3401a pmos (level=1 vto={VTO} kp=26.7 rd=31m rs=5m lambda=0.01)
M1   dx gi s s pm_ao3401a
RG1  g  gi 7.8
CGS1 gi s  590p
CGD1 gi dx 55p
CDS1 dx s  25p
* 0 V source to read the drain current (positive = S -> D -> load)
VID  dx d 0

* --- gate network -------------------------------------------------------------
R14 g s {R14}
C20 g s {C20}
C32 d g {C32}
R15 g gr {R15}
* SWN = Q2+Q3 (2N7002 in series), ideal switch: 10 Ohm on, open when off
S1  gr 0 ctl 0 sw_swn
.model sw_swn sw (vt=0.5 vh=0 ron=10 roff=1e12)

* --- output side --------------------------------------------------------------
* F1 (PTC) as a fixed 0.2 Ohm
RF1  d out 0.2
CO1  out 0 10u
CO2  out 0 100n
CL   out 0 {CL}
RBL  out 0 10k
RL   out 0 {RL}
